* Independent controlling voltage source
VCTRL 1 0 10
RCTRL 1 0 1000

* CCCS: I(F1) = 2 * I(VCTRL)
F1 2 0 VCTRL 2
R2 2 0 1000

* CCVS: V(H1) = 500 * I(VCTRL)
H1 3 0 VCTRL 500
R3 3 0 1000

* VCCS: I(G1) = 0.001 * V(1)
G1 4 0 1 0 0.001
R4 4 0 1000

* VCVS: V(E1) = 3 * V(1)
E1 5 0 1 0 3
R5 5 0 1000

.end
