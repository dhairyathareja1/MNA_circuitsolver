V1 1 0 10
E1 2 0 1 0 2
R2 2 0 1000

* Invalid: F1 is controlled by E1, not an independent V source
F1 3 0 E1 2
R3 3 0 1000

.end
