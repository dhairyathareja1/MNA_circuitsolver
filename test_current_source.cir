* Expected: V(1) = 2 V
I1 0 1 0.002
R1 1 0 1000
.end
