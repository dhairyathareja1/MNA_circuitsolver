* Expected: V(1) = 1 V, V(2) = 1 V, V(3) = 10 V
*           I(O1) = -0.001 A
V1 1 0 1
O1 3 0 1 2
R1 3 2 9000
R2 2 0 1000
.end
