* Expected: V(1) = 2 V, V(2) = 6 V, I(E1) = -0.006 A
V1 1 0 2
E1 2 0 1 0 3
R1 2 0 1000
.end
